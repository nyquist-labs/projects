* buck D=0.5 — exported by eelab.circuit
Vin vin 0 DC 12.0 AC 0.0
* switch q between vin and sw (Ron=0.05, Roff=1000000.0)
Rd_rs 0 d_int 0.01
Lf sw lx 4.7e-05
Rdcr lx out 0.03
Co out 0 0.0001
RL out 0 5
Dd d_int sw D_d
.model D_d D(Is=1e-05 N=1.05)
.end
