* twin-T — exported by eelab.circuit
Vin in 0 DC 0.0 AC 1
Ra in m1 26525.8
Rb m1 out 26525.8
Cg m1 0 2e-07
Ca in m2 1e-07
Cb m2 out 1e-07
Rg m2 0 13262.9
Rload out 0 1e+06
.end
