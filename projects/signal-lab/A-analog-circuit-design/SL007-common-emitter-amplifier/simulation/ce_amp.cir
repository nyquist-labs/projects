* CE amp — exported by eelab.circuit
Vcc vcc 0 DC 12 AC 0.0
Vin sig 0 DC 0.0 AC 1  ; time-varying in eelab
Cin sig b 1e-05
R1 vcc b 47000
R2 b 0 10000
Rc vcc c 4700
Re e 0 1000
Ce e 0 0.0001
Cout c out 1e-05
RL out 0 10000
Q1 c b e Q_1
.model Q_1 NPN(Is=6.7e-15 BF=150 BR=1 VAF=75)
.end
